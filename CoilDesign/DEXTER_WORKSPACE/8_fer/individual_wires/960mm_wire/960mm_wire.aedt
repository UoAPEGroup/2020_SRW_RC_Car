# Ansys Electronics Desktop project, version 2020.1
project variables:
  $P1 = 10mm
  $track_width = 300mm
  $box_width = ($track_width - 2*$parameter_2 - $parameter_1) / 2  # Do not change -Width of inner gaps
  $coil_diameter = 5mm  # Thickness of coil
  $parameter_1 = 120mm  # DD Coil Centre width
  $parameter_2 = 30mm  # DD Coil side width
  $Parameter_3 = 109mm  # Ferrite length secondary
  $Parameter_4 = 20mm  # Coil width secondary
  $parameter_5 = ($track_length - 2 * $parameter_2-15mm) / ($Num_Ferrites - 1)  # Do not change - spacing between ferrites
  $Parameter_6 = 218mm  # Ferrite length Primary 109 or 218
  $Num_Ferrites = 8  # ((1000mm - 2 * $parameter_2) / ($parameter_5)) + 1
  $track_length = 1000mm  # Length of the track
  $Air_Gap = 15mm  # Height of secondary solenoid above primary DD coil
  $X_displacement = 0mm  # Displacement of secondary solenoid X-axis(0 to length of track)
  $Y_displacement = 0mm  # displacement of secondary along y-axis
  $parameter_5_local = ($track_length - 2 * $parameter_2-15mm) / (7 -1)
materials:
  vacuum: permittivity=1
  copper: permeability=0.999991 conductivity=58000000
  ferrite: permittivity=12 permeability=1000 conductivity=0.01
  pec: conductivity=1e+30
  aluminum: permeability=1.000021 conductivity=38000000

design BothCoils (Maxwell 3D, EddyCurrent, model units mm)
variables:
  b1_y = 50mm
  box1width = 30mm
  box2width = $box_width
  coil_diameter = $coil_diameter
  P_2 = $parameter_2
  P_1 = ($parameter_1)
  Parameter_3 = $Parameter_3
  height_above_coil = 9mm
  Parameter_4 = $Parameter_4
  I_pt_post = 20A
geometry:
  Primary_Ferrites [ferrite] = box(corner=(-(1000mm-$parameter_2*2)/2, -$Parameter_6/2, -8mm), size=(15mm, $Parameter_6, 8mm))
  Primary_Ferrites.duplicate_along_line(step=($parameter_5, 0mm, 0mm), total=$Num_Ferrites, attached)
  Region [vacuum] = region(percentage_offset: +X=100, -X=100, +Y=500, -Y=500, +Z=3000, -Z=2000)
  coordinate_system RelativeCS1 = origin=(3 * $parameter_5 + $X_displacement -(1000mm-$parameter_2*2)/2 + 7.5mm, $Y_displacement, $Air_Gap) x=(1mm, 0mm, 0mm) y=(0mm, 1mm, 0mm)
  Secondary_Ferrite [ferrite, oriented by RelativeCS1] = box(corner=(-54.5mm, -7.5mm, 1.5mm), size=(Parameter_3, 15mm, 8mm)) in RelativeCS1
  Solenoid_Coil [copper, oriented by RelativeCS1] = box(corner=(-$Parameter_4/2, -9mm, 0), size=(Parameter_4, 18mm, 11mm)) in RelativeCS1
  Box4 = box(corner=(-$Parameter_4/2, -7.5mm, 1.5mm), size=(Parameter_4, 15mm, 8mm)) in RelativeCS1
  Solenoid_Coil.subtract(Box4)
  [Secondary_Ferrite, Solenoid_Coil].rotate(axis=Z, angle=270deg) in RelativeCS1
  Box5 [pec] = box(corner=(500mm, -150mm, -18mm), size=(-1000mm, 300mm, -2mm))
  Solenoid_Coil_Section1 [copper, oriented by RelativeCS1] = Solenoid_Coil.section(plane=YZ) in RelativeCS1
  Solenoid_Coil_Section1.separate_bodies()
  Solid1, Solid1_1, Solid1_2, Solid2, Solid2_1, Solid2_2 [copper] = imported_body(J:\UoA\2020 SUMMER\CAD files\primary_coil_0R0_960mm.stp)
  [Solid1, Solid1_1, Solid1_2, Solid2, Solid2_1, Solid2_2].rotate(axis=Z, angle=90deg)
  Solid1_Section1 = Solid1.section(plane=YZ)
  primary_wire_Section5 = Solid1_1.section(plane=YZ)
  Solid1_2_Section1 = Solid1_2.section(plane=YZ)
  Solid2_Section1 = Solid2.section(plane=YZ)
  primary_wire_Section2 = Solid2_1.section(plane=YZ)
  Solid2_2_Section1 = Solid2_2.section(plane=YZ)
  primary_wire_Section5.separate_bodies()
  primary_wire_Section4 = Solid1_2_Section1.separate_bodies()
  Solid1_2_Section1.delete()
  primary_wire_Section6 = Solid1_Section1.separate_bodies()
  Solid1_Section1.delete()
  primary_wire_Section2.separate_bodies()
  primary_wire_Section3 = Solid2_2_Section1.separate_bodies()
  Solid2_2_Section1.delete()
  primary_wire_Section1 = Solid2_Section1.separate_bodies()
  Solid2_Section1.delete()
  group primary_coil_0R0_960mm = Solid1, Solid1_1, Solid1_2, Solid2, Solid2_1, Solid2_2, primary_wire_Section5, primary_wire_Section2, primary_wire_Section4, primary_wire_Section6, primary_wire_Section3, primary_wire_Section1
boundaries and excitations:
  Aluminium: Impedance Objects=Box5 UseMaterial MaterialName=aluminum NonlinearCoefficient=5
  Lst: Current Objects=Solenoid_Coil_Section1 Phase=0deg Current=1A IsSolid=false Point_out_of_terminal=false
  Lpt_wire1: Current Objects=primary_wire_Section1 Phase=0deg Current=1A IsSolid=false Point_out_of_terminal=false
  Lpt_wire2: Current Objects=primary_wire_Section2 Phase=0deg Current=1A IsSolid=false Point_out_of_terminal=false
  Lpt_wire3: Current Objects=primary_wire_Section3 Phase=0deg Current=1A IsSolid=false Point_out_of_terminal=false
  Lpt_wire4: Current Objects=primary_wire_Section4 Phase=0deg Current=1A IsSolid=false Point_out_of_terminal=false
  Lpt_wire5: Current Objects=primary_wire_Section5 Phase=0deg Current=1A IsSolid=false Point_out_of_terminal=false
  Lpt_wire6: Current Objects=primary_wire_Section6 Phase=0deg Current=1A IsSolid=false Point_out_of_terminal=false
parameters:
  Matrix1: Matrix Lst, Lpt_wire1..Lpt_wire6:
mesh:
  initial mesh: GlobalCurvilinear{Apply}
setups:
  Setup1: EddyCurrent MaximumPasses=19 MinimumPasses=2 MinimumConvergedPasses=1 PercentRefinement=30 PercentError=1 NonLinearResidual=0.0001 Frequency=150kHz
optimetrics:
  ParametricSetup: Parametric Sim._Setups=[Setup1]
    sweep $X_displacement: LIN 0mm 100mm 10mm
    sweep $Y_displacement: LIN 0mm 50mm 10mm
    calculate Lpt_new on Setup1 : LastAdaptive at Freq 150kHz
    calculate L_st on Setup1 : LastAdaptive at Freq 150kHz
    calculate k_new on Setup1 : LastAdaptive at Freq 150kHz
    calculate Mpt_st on Setup1 : LastAdaptive at Freq 150kHz
    calculate VA_pt on Setup1 : LastAdaptive at Freq 150kHz
output variables:
  Mpt_st = Matrix1.Lnom(Lpt_wire1,Lst)+Matrix1.Lnom(Lpt_wire2,Lst)+Matrix1.Lnom(Lpt_wire3,Lst)+Matrix1.Lnom(Lpt_wire4,Lst)+Matrix1.Lnom(Lpt_wire5,Lst)+Matrix1.Lnom(Lpt_wire6,Lst)
  k_new = Mpt_st/sqrt(Lpt_new*L_st)
  M = 5*10*L_st*Lpt_new
  I_pt = 20
  VA_pt = 20*20*150000*2*pi*Lpt_new
  L_st = Matrix1.Lnom(Lst,Lst)
  Lpt_new = Matrix1.Lnom(Lpt_wire6,Lpt_wire6)+Matrix1.Lnom(Lpt_wire5,Lpt_wire6)+Matrix1.Lnom(Lpt_wire4,Lpt_wire6)+Matrix1.Lnom(Lpt_wire3,Lpt_wire6)+Matrix1.Lnom(Lpt_wire2,Lpt_wire6)+Matrix1.Lnom(Lpt_wire1,Lpt_wire6)+Matrix1.Lnom(Lpt_wire6,Lpt_wire5)+Matrix1.Lnom(Lpt_wire5,Lpt_wire5)+Matrix1.Lnom(Lpt_wire4,Lpt_wire5)+Matrix1.Lnom(Lpt_wire3,Lpt_wire5)+Matrix1.Lnom(Lpt_wire2,Lpt_wire5)+Matrix1.Lnom(Lpt_wire1,Lpt_wire1)+Matrix1.Lnom(Lpt_wire2,Lpt_wire1)+Matrix1.Lnom(Lpt_wire3,Lpt_wire1)+Matrix1.Lnom(Lpt_wire4,Lpt_wire1)+Matrix1.Lnom(Lpt_wire5,Lpt_wire1)+Matrix1.Lnom(Lpt_wire6,Lpt_wire1)+Matrix1.Lnom(Lpt_wire1,Lpt_wire2)+Matrix1.Lnom(Lpt_wire2,Lpt_wire2)+Matrix1.Lnom(Lpt_wire3,Lpt_wire2)+Matrix1.Lnom(Lpt_wire4,Lpt_wire2)+Matrix1.Lnom(Lpt_wire5,Lpt_wire2)+Matrix1.Lnom(Lpt_wire6,Lpt_wire2)+Matrix1.Lnom(Lpt_wire1,Lpt_wire3)+Matrix1.Lnom(Lpt_wire2,Lpt_wire3)+Matrix1.Lnom(Lpt_wire3,Lpt_wire3)+Matrix1.Lnom(Lpt_wire4,Lpt_wire3)+Matrix1.Lnom(Lpt_wire5,Lpt_wire3)+Matrix1.Lnom(Lpt_wire6,Lpt_wire3)+Matrix1.Lnom(Lpt_wire1,Lpt_wire4)+Matrix1.Lnom(Lpt_wire2,Lpt_wire4)+Matrix1.Lnom(Lpt_wire3,Lpt_wire4)+Matrix1.Lnom(Lpt_wire4,Lpt_wire4)+Matrix1.Lnom(Lpt_wire5,Lpt_wire4)+Matrix1.Lnom(Lpt_wire6,Lpt_wire4)+Matrix1.Lnom(Lpt_wire1,Lpt_wire5)
reports:
  Output Variables Plot 1: k_new vs $Y_displacement on Setup1 : LastAdaptive [Freq=all $X_displacement=all]
