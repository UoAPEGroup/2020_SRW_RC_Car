# Ansys Electronics Desktop project, version 2020.1
project variables:
  $track_width = 300mm
  $box_width = ($track_width - 2*$parameter_2 - $parameter_1) / 2  # Do not change -Width of inner gaps
  $coil_diameter = 4.5mm  # Thickness of coil
  $parameter_1 = 120mm  # DD Coil Centre width
  $parameter_2 = 30mm  # DD Coil side width
  $Parameter_3 = 109mm  # Ferrite length secondary
  $Parameter_4 = 20mm  # Coil width secondary
  $parameter_5 = ($track_length - 2 * $ferrite_edge_distance - 15mm) / ($Num_Ferrites - 1)  # Do not change - spacing between ferrites
  $Parameter_6 = 218mm  # Ferrite length Primary 109 or 218
  $Num_Ferrites = 8  # ((1000mm - 2 * $parameter_2) / ($parameter_5)) + 1
  $track_length = 800mm  # Length of the track
  $Air_Gap = 20mm  # Height of secondary solenoid above primary DD coil
  $X_displacement = 0mm  # Displacement of secondary solenoid X-axis(0 to length of track)
  $Y_displacement = 0mm  # displacement of secondary along y-axis
  $ferrite_edge_distance = 14.5mm
  $air_gap_between_ferrites_and_coil = 0mm
  $air_gap_between_aluminium_and_ferrites = 15mm
materials:
  vacuum: permittivity=1
  copper: permeability=0.999991 conductivity=58000000
  ferrite: permittivity=12 permeability=1000 conductivity=0.01
  pec: conductivity=1e+30
  aluminum: permeability=1.000021 conductivity=38000000

design BothCoilsWinding (Maxwell 3D, EddyCurrent, model units mm)
variables:
  b1_y = 50mm
  box1width = 30mm
  box2width = $box_width
  coil_diameter = $coil_diameter
  P_2 = $parameter_2
  P_1 = ($parameter_1)
  Parameter_3 = $Parameter_3
  height_above_coil = 9mm
  Parameter_4 = $Parameter_4
  I_pt_post = 20A
geometry:
  Primary_Ferrites [ferrite] = box(corner=(-(800mm-$ferrite_edge_distance*2)/2, -$Parameter_6/2, - (8mm + $air_gap_between_ferrites_and_coil)), size=(15mm, $Parameter_6, 8mm))
  Primary_Ferrites.duplicate_along_line(step=($parameter_5, 0mm, 0mm), total=$Num_Ferrites, attached)
  Region [vacuum] = region(percentage_offset: +X=100, -X=100, +Y=500, -Y=500, +Z=3000, -Z=2000)
  coordinate_system RelativeCS1 = origin=(3 * $parameter_5 + $X_displacement -(800mm-$ferrite_edge_distance*2)/2 + 7.5mm, $Y_displacement, $Air_Gap) x=(1mm, 0mm, 0mm) y=(0mm, 1mm, 0mm)
  Secondary_Ferrite [ferrite, oriented by RelativeCS1] = box(corner=(-54.5mm, -7.5mm, 1.5mm), size=(Parameter_3, 15mm, 8mm)) in RelativeCS1
  Solenoid_Coil [copper, oriented by RelativeCS1] = box(corner=(-$Parameter_4/2, -9mm, 0), size=(Parameter_4, 18mm, 11mm)) in RelativeCS1
  Box4 = box(corner=(-$Parameter_4/2, -7.5mm, 1.5mm), size=(Parameter_4, 15mm, 8mm)) in RelativeCS1
  Solenoid_Coil.subtract(Box4)
  [Secondary_Ferrite, Solenoid_Coil].rotate(axis=Z, angle=270deg) in RelativeCS1
  Box5 [pec] = box(corner=(400mm, -150mm, - (8mm + $air_gap_between_ferrites_and_coil + $air_gap_between_aluminium_and_ferrites)), size=(-800mm, 300mm, -2mm))
  Solenoid_Coil_Section1 [copper, oriented by RelativeCS1] = Solenoid_Coil.section(plane=YZ) in RelativeCS1
  Solenoid_Coil_Section1.separate_bodies()
  primary_wire6, primary_wire5, primary_wire4, primary_wire1, primary_wire2, primary_wire3 [copper] = imported_body(H:\SUMMER 2020\oldGitRevert\2020-srw-rc-car\CoilDesign\DEXTER_WORKSPACE\CAD stuff\primary_coil_0R1_800mm.stp)
  [primary_wire6, primary_wire5, primary_wire4, primary_wire1, primary_wire2, primary_wire3].rotate(axis=Z, angle=90deg)
  primary_wire_section6 [copper] = primary_wire6.section(plane=YZ)
  Solid1_1_Section1 = primary_wire5.section(plane=YZ)
  primary_wire_section4 [copper] = primary_wire4.section(plane=YZ)
  primary_wire_section1 [copper] = primary_wire1.section(plane=YZ)
  Solid2_1_Section1 = primary_wire2.section(plane=YZ)
  primary_wire_section3 [copper] = primary_wire3.section(plane=YZ)
  primary_wire_section6.separate_bodies()
  primary_wire_section5 [copper] = Solid1_1_Section1.separate_bodies()
  Solid1_1_Section1.delete()
  primary_wire_section4.separate_bodies()
  primary_wire_section1.separate_bodies()
  primary_wire_section2 [copper] = Solid2_1_Section1.separate_bodies()
  Solid2_1_Section1.delete()
  primary_wire_section3.separate_bodies()
  group primary_coil_0R1_800mm = primary_wire6, primary_wire5, primary_wire4, primary_wire1, primary_wire2, primary_wire3, primary_wire_section6, primary_wire_section4, primary_wire_section1, primary_wire_section3, primary_wire_section5, primary_wire_section2
boundaries and excitations:
  Aluminium: Impedance Objects=Box5 UseMaterial MaterialName=aluminum NonlinearCoefficient=5
  Lpt_Ter_1: Coil Terminal Objects=primary_wire_section1 Conductor_number=1 Winding=Lpt_Wdg Point_out_of_terminal=false
  Lpt_Ter_2: Coil Terminal Objects=primary_wire_section2 Conductor_number=1 Winding=Lpt_Wdg Point_out_of_terminal=false
  Lpt_Ter_3: Coil Terminal Objects=primary_wire_section3 Conductor_number=1 Winding=Lpt_Wdg Point_out_of_terminal=false
  Lpt_Ter_4: Coil Terminal Objects=primary_wire_section4 Conductor_number=1 Winding=Lpt_Wdg Point_out_of_terminal=false
  Lpt_Ter_5: Coil Terminal Objects=primary_wire_section5 Conductor_number=1 Winding=Lpt_Wdg Point_out_of_terminal=false
  Lpt_Ter_6: Coil Terminal Objects=primary_wire_section6 Conductor_number=1 Winding=Lpt_Wdg Point_out_of_terminal=false
  Lst_Ter: Coil Terminal Objects=Solenoid_Coil_Section1 Conductor_number=1 Winding=Lst_Wdg Point_out_of_terminal=false
  Lpt_Wdg: Winding Group Type=Current IsSolid=false Current=1A ParallelBranchesNum=1 Phase=0deg
  Lst_Wdg: Winding Group Type=Current IsSolid=false Current=1A ParallelBranchesNum=1 Phase=0deg
parameters:
  Matrix1: Matrix Lpt_Wdg, Lst_Wdg:
mesh:
  initial mesh: GlobalCurvilinear{Apply}
setups:
  Setup1: EddyCurrent MaximumPasses=17 MinimumPasses=2 MinimumConvergedPasses=1 PercentRefinement=30 PercentError=1 NonLinearResidual=0.0001 Frequency=150kHz
optimetrics:
  ParametricSetup: Parametric Sim._Setups=[Setup1]
    sweep $X_displacement: LIN 0mm 108mm 10.8mm
    sweep $Y_displacement: LIN 0mm 50mm 12.5mm
    calculate Lst_Wdg on Setup1 : LastAdaptive at Freq 150kHz
    calculate k_Wdg on Setup1 : LastAdaptive at Freq 150kHz
    calculate M_Wdg on Setup1 : LastAdaptive at Freq 150kHz
    calculate L_pt_Wdg on Setup1 : LastAdaptive at Freq 150kHz
output variables:
  I_pt = 20
  L_pt_Wdg = L(Lpt_Wdg,Lpt_Wdg)
  Lst_Wdg = L(Lst_Wdg,Lst_Wdg)
  M_Wdg = L(Lpt_Wdg,Lst_Wdg)
  k_Wdg = M_Wdg/sqrt(L_pt_Wdg*Lst_Wdg)
field plots:
  Mesh1: MeshPlots in Primary_Ferrites on Setup1 : LastAdaptive at Freq=150kHz Phase=0deg
  ComplexMag_B1: B in Primary_Ferrites on Setup1 : LastAdaptive at Freq=150kHz Phase=0deg
reports:
  Output Variables Table 1: L_pt_Wdg, M_Wdg, Lst_Wdg, k_Wdg vs Freq on Setup1 : LastAdaptive [$X_displacement=all $Y_displacement=all]
  Output Variables Plot 1: k_Wdg vs $Y_displacement on Setup1 : LastAdaptive [$X_displacement=all Freq=all]
